# Ansys Electronics Desktop project, version 2025.2

design main_SIwizard1 (Circuit)
options: SParamCircuitDef IntegrationMethod=FFT
components:
  U100 = main(Net(SD_A0_23_W9825G6KH-6_U5_ref)=0 Net(SD_A0_T6_LFE5U-25F-6BG256C_U1_ref)=0 Net(SD_A1_24_W9825G6KH-6_U5_ref)=0 Net(SD_A1_T4_LFE5U-25F-6BG256C_U1_ref)=0 Net(SD_A2_25_W9825G6KH-6_U5_ref)=0 Net(SD_A2_T3_LFE5U-25F-6BG256C_U1_ref)=0 Net(SD_A3_26_W9825G6KH-6_U5_ref)=0 Net(SD_A3_T2_LFE5U-25F-6BG256C_U1_ref)=0 Net(SD_A4_29_W9825G6KH-6_U5_ref)=0 Net(SD_A4_A2_LFE5U-25F-6BG256C_U1_ref)=0 Net(SD_A5_30_W9825G6KH-6_U5_ref)=0 Net(SD_A5_A3_LFE5U-25F-6BG256C_U1_ref)=0 Net(SD_A6_31_W9825G6KH-6_U5_ref)=0 Net(SD_A6_A4_LFE5U-25F-6BG256C_U1_ref)=0 Net(SD_BA0_1_0402WGF330JTCE_R54_ref)=0 Net(SD_BA0_K12_LFE5U-25F-6BG256C_U1_ref)=0 Net(SD_BA1_1_0402WGF330JTCE_R53_ref)=0 Net(SD_BA1_L12_LFE5U-25F-6BG256C_U1_ref)=0 Net(SD_CLK_2_0402WGF330JTCE_R2_ref)=0 Net(SD_CLK_J15_LFE5U-25F-6BG256C_U1_ref)=0 Net(SD_CS_N_1_0402WGF330JTCE_R51_ref)=0 Net(SD_CS_N_R15_LFE5U-25F-6BG256C_U1_ref)=0 Net(SD_DQ0_2_W9825G6KH-6_U5_ref)=0 Net(SD_DQ0_L15_LFE5U-25F-6BG256C_U1_ref)=0 Net(SD_DQ1_4_W9825G6KH-6_U5_ref)=0 Net(SD_DQ1_M16_LFE5U-25F-6BG256C_U1_ref)=0 Net(SD_DQ2_5_W9825G6KH-6_U5_ref)=0 Net(SD_DQ2_K16_LFE5U-25F-6BG256C_U1_ref)=0 Net(SD_DQ3_7_W9825G6KH-6_U5_ref)=0 Net(SD_DQ3_M15_LFE5U-25F-6BG256C_U1_ref)=0 Net(SD_DQ4_8_W9825G6KH-6_U5_ref)=0 Net(SD_DQ4_M14_LFE5U-25F-6BG256C_U1_ref)=0 Net(SD_DQ5_10_W9825G6KH-6_U5_ref)=0 Net(SD_DQ5_P16_LFE5U-25F-6BG256C_U1_ref)=0 Net(SD_DQ6_11_W9825G6KH-6_U5_ref)=0 Net(SD_DQ6_R16_LFE5U-25F-6BG256C_U1_ref)=0 Net(SD_DQ7_13_W9825G6KH-6_U5_ref)=0 Net(SD_DQ7_J16_LFE5U-25F-6BG256C_U1_ref)=0 Net(SD_DQ8_4)
  UU1_SD_CS_N_tx = SD_CS_N_SAPPHIRE_FPGA-new(model=lvc330s080eaaaaaaaou buffer=output polarity=Non-Inverting typ=typ,min,max,fast,slow pkg_selector=Pin)
  AEYESRC0 = EYESOURCE(resistance=50ohm vlow=0 vhigh=1 trise=1e-12 tfall=1e-12 UIorBPS=UnitInterval UIorBPSValue=50ns repeat_count=5 phase_delay=1e-09)
  Z2280 = VPROBE(Name=SD_CS_N_R15_U1_tx)
  UU1_SD_BA0_tx = SD_BA[0]_SAPPHIRE_FPGA-new(model=lvc330s080eaaaaaaaou buffer=output polarity=Non-Inverting typ=typ,min,max,fast,slow pkg_selector=Pin)
  AEYESRC1 = EYESOURCE(resistance=50ohm vlow=0 vhigh=1 trise=1e-12 tfall=1e-12 UIorBPS=UnitInterval UIorBPSValue=50ns repeat_count=5 phase_delay=1e-09)
  Z2350 = VPROBE(Name=SD_BA0_K12_U1_tx)
  UU1_SD_BA1_tx = SD_BA[1]_SAPPHIRE_FPGA-new(model=lvc330s080eaaaaaaaou buffer=output polarity=Non-Inverting typ=typ,min,max,fast,slow pkg_selector=Pin)
  AEYESRC2 = EYESOURCE(resistance=50ohm vlow=0 vhigh=1 trise=1e-12 tfall=1e-12 UIorBPS=UnitInterval UIorBPSValue=50ns repeat_count=5 phase_delay=1e-09)
  Z2420 = VPROBE(Name=SD_BA1_L12_U1_tx)
  UU1_SD_DQM1_tx = SD_DQM[1]_SAPPHIRE_FPGA-new(model=lvc330s080eaaaaaaaou buffer=output polarity=Non-Inverting typ=typ,min,max,fast,slow pkg_selector=Pin)
  AEYESRC3 = EYESOURCE(resistance=50ohm vlow=0 vhigh=1 trise=1e-12 tfall=1e-12 UIorBPS=UnitInterval UIorBPSValue=50ns repeat_count=5 phase_delay=1e-09)
  Z2490 = VPROBE(Name=SD_DQM1_D14_U1_tx)
  UU1_SD_CLK_tx = SD_CLK_SAPPHIRE_FPGA-new(model=lvc330s080eaaaaaaaou buffer=output polarity=Non-Inverting typ=typ,min,max,fast,slow pkg_selector=Pin)
  AEYESRC4 = EYESOURCE(resistance=50ohm vlow=0 vhigh=1 trise=1e-12 tfall=1e-12 UIorBPS=UnitInterval UIorBPSValue=50ns repeat_count=5 phase_delay=1e-09)
  Z2560 = VPROBE(Name=SD_CLK_J15_U1_tx)
  UU1_SD_A4_tx = SD_A[4]_SAPPHIRE_FPGA-new(model=lvc330s080eaaaaaaaou buffer=output polarity=Non-Inverting typ=typ,min,max,fast,slow pkg_selector=Pin)
  AEYESRC5 = EYESOURCE(resistance=50ohm vlow=0 vhigh=1 trise=1e-12 tfall=1e-12 UIorBPS=UnitInterval UIorBPSValue=50ns repeat_count=5 phase_delay=1e-09)
  Z2630 = VPROBE(Name=SD_A4_A2_U1_tx)
  UU1_SD_A6_tx = SD_A[6]_SAPPHIRE_FPGA-new(model=lvc330s080eaaaaaaaou buffer=output polarity=Non-Inverting typ=typ,min,max,fast,slow pkg_selector=Pin)
  AEYESRC6 = EYESOURCE(resistance=50ohm vlow=0 vhigh=1 trise=1e-12 tfall=1e-12 UIorBPS=UnitInterval UIorBPSValue=50ns repeat_count=5 phase_delay=1e-09)
  Z2700 = VPROBE(Name=SD_A6_A4_U1_tx)
  UU1_SD_A5_tx = SD_A[5]_SAPPHIRE_FPGA-new(model=lvc330s080eaaaaaaaou buffer=output polarity=Non-Inverting typ=typ,min,max,fast,slow pkg_selector=Pin)
  AEYESRC7 = EYESOURCE(resistance=50ohm vlow=0 vhigh=1 trise=1e-12 tfall=1e-12 UIorBPS=UnitInterval UIorBPSValue=50ns repeat_count=5 phase_delay=1e-09)
  Z2770 = VPROBE(Name=SD_A5_A3_U1_tx)
  UU1_SD_A0_tx = SD_A[4]_SAPPHIRE_FPGA-new(model=lvc330s080eaaaaaaaou buffer=output polarity=Non-Inverting typ=typ,min,max,fast,slow pkg_selector=Pin)
  AEYESRC8 = EYESOURCE(resistance=50ohm vlow=0 vhigh=1 trise=1e-12 tfall=1e-12 UIorBPS=UnitInterval UIorBPSValue=50ns repeat_count=5 phase_delay=1e-09)
  Z2840 = VPROBE(Name=SD_A0_T6_U1_tx)
  UU1_SD_A2_tx = SD_A[2]_SAPPHIRE_FPGA-new(model=lvc330s080eaaaaaaaou buffer=output polarity=Non-Inverting typ=typ,min,max,fast,slow pkg_selector=Pin)
  AEYESRC9 = EYESOURCE(resistance=50ohm vlow=0 vhigh=1 trise=1e-12 tfall=1e-12 UIorBPS=UnitInterval UIorBPSValue=50ns repeat_count=5 phase_delay=1e-09)
  Z2910 = VPROBE(Name=SD_A2_T3_U1_tx)
  UU1_SD_A1_tx = SD_A[1]_SAPPHIRE_FPGA-new(model=lvc330s080eaaaaaaaou buffer=output polarity=Non-Inverting typ=typ,min,max,fast,slow pkg_selector=Pin)
  AEYESRC10 = EYESOURCE(resistance=50ohm vlow=0 vhigh=1 trise=1e-12 tfall=1e-12 UIorBPS=UnitInterval UIorBPSValue=50ns repeat_count=5 phase_delay=1e-09)
  Z2980 = VPROBE(Name=SD_A1_T4_U1_tx)
  UU1_SD_A3_tx = SD_A[3]_SAPPHIRE_FPGA-new(model=lvc330s080eaaaaaaaou buffer=output polarity=Non-Inverting typ=typ,min,max,fast,slow pkg_selector=Pin)
  AEYESRC11 = EYESOURCE(resistance=50ohm vlow=0 vhigh=1 trise=1e-12 tfall=1e-12 UIorBPS=UnitInterval UIorBPSValue=50ns repeat_count=5 phase_delay=1e-09)
  Z3050 = VPROBE(Name=SD_A3_T2_U1_tx)
  UU5_SD_DQ2_tx = DQ2_W9825G6KH_W9825G6KH_-40~85C(model=I/O buffer=input_output polarity=Non-Inverting typ=typ,min,max,fast,slow pkg_selector=Pin)
  AEYESRC12 = EYESOURCE(resistance=50ohm vlow=0 vhigh=1 trise=1e-12 tfall=1e-12 UIorBPS=UnitInterval UIorBPSValue=50ns repeat_count=5 phase_delay=1e-09)
  Z3120 = VPROBE(Name=SD_DQ2_5_U5_tx)
  UU1_SD_DQM0_tx = SD_DQM[0]_SAPPHIRE_FPGA-new(model=lvc330s080eaaaaaaaou buffer=output polarity=Non-Inverting typ=typ,min,max,fast,slow pkg_selector=Pin)
  AEYESRC13 = EYESOURCE(resistance=50ohm vlow=0 vhigh=1 trise=1e-12 tfall=1e-12 UIorBPS=UnitInterval UIorBPSValue=50ns repeat_count=5 phase_delay=1e-09)
  Z3190 = VPROBE(Name=SD_DQM0_T15_U1_tx)
  UU5_SD_DQ0_tx = DQ0_W9825G6KH_W9825G6KH_-40~85C(model=I/O buffer=input_output polarity=Non-Inverting typ=typ,min,max,fast,slow pkg_selector=Pin)
  AEYESRC14 = EYESOURCE(resistance=50ohm vlow=0 vhigh=1 trise=1e-12 tfall=1e-12 UIorBPS=UnitInterval UIorBPSValue=50ns repeat_count=5 phase_delay=1e-09)
  Z3260 = VPROBE(Name=SD_DQ0_2_U5_tx)
  UU5_SD_DQ7_tx = DQ7_W9825G6KH_W9825G6KH_-40~85C(model=I/O buffer=input_output polarity=Non-Inverting typ=typ,min,max,fast,slow pkg_selector=Pin)
  AEYESRC15 = EYESOURCE(resistance=50ohm vlow=0 vhigh=1 trise=1e-12 tfall=1e-12 UIorBPS=UnitInterval UIorBPSValue=50ns repeat_count=5 phase_delay=1e-09)
  Z3330 = VPROBE(Name=SD_DQ7_13_U5_tx)
  UU5_SD_DQ6_tx = DQ6_W9825G6KH_W9825G6KH_-40~85C(model=I/O buffer=input_output polarity=Non-Inverting typ=typ,min,max,fast,slow pkg_selector=Pin)
  AEYESRC16 = EYESOURCE(resistance=50ohm vlow=0 vhigh=1 trise=1e-12 tfall=1e-12 UIorBPS=UnitInterval UIorBPSValue=50ns repeat_count=5 phase_delay=1e-09)
  Z3400 = VPROBE(Name=SD_DQ6_11_U5_tx)
  UU5_SD_DQ1_tx = DQ1_W9825G6KH_W9825G6KH_-40~85C(model=I/O buffer=input_output polarity=Non-Inverting typ=typ,min,max,fast,slow pkg_selector=Pin)
  AEYESRC17 = EYESOURCE(resistance=50ohm vlow=0 vhigh=1 trise=1e-12 tfall=1e-12 UIorBPS=UnitInterval UIorBPSValue=50ns repeat_count=5 phase_delay=1e-09)
  Z3470 = VPROBE(Name=SD_DQ1_4_U5_tx)
  UU5_SD_DQ4_tx = DQ4_W9825G6KH_W9825G6KH_-40~85C(model=I/O buffer=input_output polarity=Non-Inverting typ=typ,min,max,fast,slow pkg_selector=Pin)
  AEYESRC18 = EYESOURCE(resistance=50ohm vlow=0 vhigh=1 trise=1e-12 tfall=1e-12 UIorBPS=UnitInterval UIorBPSValue=50ns repeat_count=5 phase_delay=1e-09)
  Z3540 = VPROBE(Name=SD_DQ4_8_U5_tx)
  UU5_SD_DQ5_tx = DQ5_W9825G6KH_W9825G6KH_-40~85C(model=I/O buffer=input_output polarity=Non-Inverting typ=typ,min,max,fast,slow pkg_selector=Pin)
  AEYESRC19 = EYESOURCE(resistance=50ohm vlow=0 vhigh=1 trise=1e-12 tfall=1e-12 UIorBPS=UnitInterval UIorBPSValue=50ns repeat_count=5 phase_delay=1e-09)
  Z3610 = VPROBE(Name=SD_DQ5_10_U5_tx)
  UU5_SD_DQ3_tx = DQ3_W9825G6KH_W9825G6KH_-40~85C(model=I/O buffer=input_output polarity=Non-Inverting typ=typ,min,max,fast,slow pkg_selector=Pin)
  AEYESRC20 = EYESOURCE(resistance=50ohm vlow=0 vhigh=1 trise=1e-12 tfall=1e-12 UIorBPS=UnitInterval UIorBPSValue=50ns repeat_count=5 phase_delay=1e-09)
  Z3680 = VPROBE(Name=SD_DQ3_7_U5_tx)
  UU5_SD_DQ13_tx = DQ13_W9825G6KH_W9825G6KH_-40~85C(model=I/O buffer=input_output polarity=Non-Inverting typ=typ,min,max,fast,slow pkg_selector=Pin)
  AEYESRC21 = EYESOURCE(resistance=50ohm vlow=0 vhigh=1 trise=1e-12 tfall=1e-12 UIorBPS=UnitInterval UIorBPSValue=50ns repeat_count=5 phase_delay=1e-09)
  Z3750 = VPROBE(Name=SD_DQ13_50_U5_tx)
  UU5_SD_DQ8_tx = DQ8_W9825G6KH_W9825G6KH_-40~85C(model=I/O buffer=input_output polarity=Non-Inverting typ=typ,min,max,fast,slow pkg_selector=Pin)
  AEYESRC22 = EYESOURCE(resistance=50ohm vlow=0 vhigh=1 trise=1e-12 tfall=1e-12 UIorBPS=UnitInterval UIorBPSValue=50ns repeat_count=5 phase_delay=1e-09)
  Z3820 = VPROBE(Name=SD_DQ8_42_U5_tx)
  UU5_SD_DQ15_tx = DQ15_W9825G6KH_W9825G6KH_-40~85C(model=I/O buffer=input_output polarity=Non-Inverting typ=typ,min,max,fast,slow pkg_selector=Pin)
  AEYESRC23 = EYESOURCE(resistance=50ohm vlow=0 vhigh=1 trise=1e-12 tfall=1e-12 UIorBPS=UnitInterval UIorBPSValue=50ns repeat_count=5 phase_delay=1e-09)
  Z3890 = VPROBE(Name=SD_DQ15_53_U5_tx)
  UU5_SD_DQ14_tx = DQ14_W9825G6KH_W9825G6KH_-40~85C(model=I/O buffer=input_output polarity=Non-Inverting typ=typ,min,max,fast,slow pkg_selector=Pin)
  AEYESRC24 = EYESOURCE(resistance=50ohm vlow=0 vhigh=1 trise=1e-12 tfall=1e-12 UIorBPS=UnitInterval UIorBPSValue=50ns repeat_count=5 phase_delay=1e-09)
  Z3960 = VPROBE(Name=SD_DQ14_51_U5_tx)
  UU5_SD_DQ11_tx = DQ11_W9825G6KH_W9825G6KH_-40~85C(model=I/O buffer=input_output polarity=Non-Inverting typ=typ,min,max,fast,slow pkg_selector=Pin)
  AEYESRC25 = EYESOURCE(resistance=50ohm vlow=0 vhigh=1 trise=1e-12 tfall=1e-12 UIorBPS=UnitInterval UIorBPSValue=50ns repeat_count=5 phase_delay=1e-09)
  Z4030 = VPROBE(Name=SD_DQ11_47_U5_tx)
  UU5_SD_DQ12_tx = DQ12_W9825G6KH_W9825G6KH_-40~85C(model=I/O buffer=input_output polarity=Non-Inverting typ=typ,min,max,fast,slow pkg_selector=Pin)
  AEYESRC26 = EYESOURCE(resistance=50ohm vlow=0 vhigh=1 trise=1e-12 tfall=1e-12 UIorBPS=UnitInterval UIorBPSValue=50ns repeat_count=5 phase_delay=1e-09)
  Z4100 = VPROBE(Name=SD_DQ12_48_U5_tx)
  UU5_SD_DQ9_tx = DQ9_W9825G6KH_W9825G6KH_-40~85C(model=I/O buffer=input_output polarity=Non-Inverting typ=typ,min,max,fast,slow pkg_selector=Pin)
  AEYESRC27 = EYESOURCE(resistance=50ohm vlow=0 vhigh=1 trise=1e-12 tfall=1e-12 UIorBPS=UnitInterval UIorBPSValue=50ns repeat_count=5 phase_delay=1e-09)
  Z4170 = VPROBE(Name=SD_DQ9_44_U5_tx)
  UU5_SD_DQ10_tx = DQ10_W9825G6KH_W9825G6KH_-40~85C(model=I/O buffer=input_output polarity=Non-Inverting typ=typ,min,max,fast,slow pkg_selector=Pin)
  AEYESRC28 = EYESOURCE(resistance=50ohm vlow=0 vhigh=1 trise=1e-12 tfall=1e-12 UIorBPS=UnitInterval UIorBPSValue=50ns repeat_count=5 phase_delay=1e-09)
  Z4240 = VPROBE(Name=SD_DQ10_45_U5_tx)
  UR51_SD_CS_N_rx = LDQM_W9825G6KH_W9825G6KH_-40~85C(model=Input buffer=input polarity=Non-Inverting typ=typ,min,max,fast,slow pkg_selector=Pin)
  Z4300 = VPROBE(Name=SD_CS_N_1_R51_rx)
  A4310 = EYEPROBE(source_name=AEYESOURCEEYESRC0 Name=SD_CS_N_1_R51_rx_eye)
  UR54_SD_BA0_rx = LDQM_W9825G6KH_W9825G6KH_-40~85C(model=Input buffer=input polarity=Non-Inverting typ=typ,min,max,fast,slow pkg_selector=Pin)
  Z4380 = VPROBE(Name=SD_BA0_1_R54_rx)
  A4390 = EYEPROBE(source_name=AEYESOURCEEYESRC1 Name=SD_BA0_1_R54_rx_eye)
  UR53_SD_BA1_rx = LDQM_W9825G6KH_W9825G6KH_-40~85C(model=Input buffer=input polarity=Non-Inverting typ=typ,min,max,fast,slow pkg_selector=Pin)
  Z4460 = VPROBE(Name=SD_BA1_1_R53_rx)
  A4470 = EYEPROBE(source_name=AEYESOURCEEYESRC2 Name=SD_BA1_1_R53_rx_eye)
  UU5_SD_DQM1_rx = UDQM_W9825G6KH_W9825G6KH_-40~85C(model=Input buffer=input polarity=Non-Inverting typ=typ,min,max,fast,slow pkg_selector=Pin)
  Z4540 = VPROBE(Name=SD_DQM1_39_U5_rx)
  A4550 = EYEPROBE(source_name=AEYESOURCEEYESRC3 Name=SD_DQM1_39_U5_rx_eye)
  UR2_SD_CLK_rx = LDQM_W9825G6KH_W9825G6KH_-40~85C(model=Input buffer=input polarity=Non-Inverting typ=typ,min,max,fast,slow pkg_selector=Pin)
  Z4620 = VPROBE(Name=SD_CLK_2_R2_rx)
  A4630 = EYEPROBE(source_name=AEYESOURCEEYESRC4 Name=SD_CLK_2_R2_rx_eye)
  UU5_SD_A4_rx = A4_W9825G6KH_W9825G6KH_-40~85C(model=Input buffer=input polarity=Non-Inverting typ=typ,min,max,fast,slow pkg_selector=Pin)
  Z4700 = VPROBE(Name=SD_A4_29_U5_rx)
  A4710 = EYEPROBE(source_name=AEYESOURCEEYESRC5 Name=SD_A4_29_U5_rx_eye)
  UU5_SD_A6_rx = A6_W9825G6KH_W9825G6KH_-40~85C(model=Input buffer=input polarity=Non-Inverting typ=typ,min,max,fast,slow pkg_selector=Pin)
  Z4780 = VPROBE(Name=SD_A6_31_U5_rx)
  A4790 = EYEPROBE(source_name=AEYESOURCEEYESRC6 Name=SD_A6_31_U5_rx_eye)
  UU5_SD_A5_rx = A5_W9825G6KH_W9825G6KH_-40~85C(model=Input buffer=input polarity=Non-Inverting typ=typ,min,max,fast,slow pkg_selector=Pin)
  Z4860 = VPROBE(Name=SD_A5_30_U5_rx)
  A4870 = EYEPROBE(source_name=AEYESOURCEEYESRC7 Name=SD_A5_30_U5_rx_eye)
  UU5_SD_A0_rx = A0_W9825G6KH_W9825G6KH_-40~85C(model=Input buffer=input polarity=Non-Inverting typ=typ,min,max,fast,slow pkg_selector=Pin)
  Z4940 = VPROBE(Name=SD_A0_23_U5_rx)
  A4950 = EYEPROBE(source_name=AEYESOURCEEYESRC8 Name=SD_A0_23_U5_rx_eye)
  UU5_SD_A2_rx = A2_W9825G6KH_W9825G6KH_-40~85C(model=Input buffer=input polarity=Non-Inverting typ=typ,min,max,fast,slow pkg_selector=Pin)
  Z5020 = VPROBE(Name=SD_A2_25_U5_rx)
  A5030 = EYEPROBE(source_name=AEYESOURCEEYESRC9 Name=SD_A2_25_U5_rx_eye)
  UU5_SD_A1_rx = A1_W9825G6KH_W9825G6KH_-40~85C(model=Input buffer=input polarity=Non-Inverting typ=typ,min,max,fast,slow pkg_selector=Pin)
  Z5100 = VPROBE(Name=SD_A1_24_U5_rx)
  A5110 = EYEPROBE(source_name=AEYESOURCEEYESRC10 Name=SD_A1_24_U5_rx_eye)
  UU5_SD_A3_rx = A3_W9825G6KH_W9825G6KH_-40~85C(model=Input buffer=input polarity=Non-Inverting typ=typ,min,max,fast,slow pkg_selector=Pin)
  Z5180 = VPROBE(Name=SD_A3_26_U5_rx)
  A5190 = EYEPROBE(source_name=AEYESOURCEEYESRC11 Name=SD_A3_26_U5_rx_eye)
  UU1_SD_DQ2_rx = CCLK_SAPPHIRE_FPGA-new(model=lvc330axxxeaaaaaaain buffer=input polarity=Non-Inverting typ=typ,min,max,fast,slow pkg_selector=Pin)
  Z5260 = VPROBE(Name=SD_DQ2_K16_U1_rx)
  A5270 = EYEPROBE(source_name=AEYESOURCEEYESRC12 Name=SD_DQ2_K16_U1_rx_eye)
  UU5_SD_DQM0_rx = LDQM_W9825G6KH_W9825G6KH_-40~85C(model=Input buffer=input polarity=Non-Inverting typ=typ,min,max,fast,slow pkg_selector=Pin)
  Z5340 = VPROBE(Name=SD_DQM0_15_U5_rx)
  A5350 = EYEPROBE(source_name=AEYESOURCEEYESRC13 Name=SD_DQM0_15_U5_rx_eye)
  UU1_SD_DQ0_rx = CCLK_SAPPHIRE_FPGA-new(model=lvc330axxxeaaaaaaain buffer=input polarity=Non-Inverting typ=typ,min,max,fast,slow pkg_selector=Pin)
  Z5420 = VPROBE(Name=SD_DQ0_L15_U1_rx)
  A5430 = EYEPROBE(source_name=AEYESOURCEEYESRC14 Name=SD_DQ0_L15_U1_rx_eye)
  UU1_SD_DQ7_rx = CCLK_SAPPHIRE_FPGA-new(model=lvc330axxxeaaaaaaain buffer=input polarity=Non-Inverting typ=typ,min,max,fast,slow pkg_selector=Pin)
  Z5500 = VPROBE(Name=SD_DQ7_J16_U1_rx)
  A5510 = EYEPROBE(source_name=AEYESOURCEEYESRC15 Name=SD_DQ7_J16_U1_rx_eye)
  UU1_SD_DQ6_rx = CCLK_SAPPHIRE_FPGA-new(model=lvc330axxxeaaaaaaain buffer=input polarity=Non-Inverting typ=typ,min,max,fast,slow pkg_selector=Pin)
  Z5580 = VPROBE(Name=SD_DQ6_R16_U1_rx)
  A5590 = EYEPROBE(source_name=AEYESOURCEEYESRC16 Name=SD_DQ6_R16_U1_rx_eye)
  UU1_SD_DQ1_rx = CCLK_SAPPHIRE_FPGA-new(model=lvc330axxxeaaaaaaain buffer=input polarity=Non-Inverting typ=typ,min,max,fast,slow pkg_selector=Pin)
  Z5660 = VPROBE(Name=SD_DQ1_M16_U1_rx)
  A5670 = EYEPROBE(source_name=AEYESOURCEEYESRC17 Name=SD_DQ1_M16_U1_rx_eye)
  UU1_SD_DQ4_rx = CCLK_SAPPHIRE_FPGA-new(model=lvc330axxxeaaaaaaain buffer=input polarity=Non-Inverting typ=typ,min,max,fast,slow pkg_selector=Pin)
  Z5740 = VPROBE(Name=SD_DQ4_M14_U1_rx)
  A5750 = EYEPROBE(source_name=AEYESOURCEEYESRC18 Name=SD_DQ4_M14_U1_rx_eye)
  UU1_SD_DQ5_rx = CCLK_SAPPHIRE_FPGA-new(model=lvc330axxxeaaaaaaain buffer=input polarity=Non-Inverting typ=typ,min,max,fast,slow pkg_selector=Pin)
  Z5820 = VPROBE(Name=SD_DQ5_P16_U1_rx)
  A5830 = EYEPROBE(source_name=AEYESOURCEEYESRC19 Name=SD_DQ5_P16_U1_rx_eye)
  UU1_SD_DQ3_rx = CCLK_SAPPHIRE_FPGA-new(model=lvc330axxxeaaaaaaain buffer=input polarity=Non-Inverting typ=typ,min,max,fast,slow pkg_selector=Pin)
  Z5900 = VPROBE(Name=SD_DQ3_M15_U1_rx)
  A5910 = EYEPROBE(source_name=AEYESOURCEEYESRC20 Name=SD_DQ3_M15_U1_rx_eye)
  UU1_SD_DQ13_rx = CCLK_SAPPHIRE_FPGA-new(model=lvc330axxxeaaaaaaain buffer=input polarity=Non-Inverting typ=typ,min,max,fast,slow pkg_selector=Pin)
  Z5980 = VPROBE(Name=SD_DQ13_G15_U1_rx)
  A5990 = EYEPROBE(source_name=AEYESOURCEEYESRC21 Name=SD_DQ13_G15_U1_rx_eye)
  UU1_SD_DQ8_rx = CCLK_SAPPHIRE_FPGA-new(model=lvc330axxxeaaaaaaain buffer=input polarity=Non-Inverting typ=typ,min,max,fast,slow pkg_selector=Pin)
  Z6060 = VPROBE(Name=SD_DQ8_D16_U1_rx)
  A6070 = EYEPROBE(source_name=AEYESOURCEEYESRC22 Name=SD_DQ8_D16_U1_rx_eye)
  UU1_SD_DQ15_rx = CCLK_SAPPHIRE_FPGA-new(model=lvc330axxxeaaaaaaain buffer=input polarity=Non-Inverting typ=typ,min,max,fast,slow pkg_selector=Pin)
  Z6140 = VPROBE(Name=SD_DQ15_H15_U1_rx)
  A6150 = EYEPROBE(source_name=AEYESOURCEEYESRC23 Name=SD_DQ15_H15_U1_rx_eye)
  UU1_SD_DQ14_rx = CCLK_SAPPHIRE_FPGA-new(model=lvc330axxxeaaaaaaain buffer=input polarity=Non-Inverting typ=typ,min,max,fast,slow pkg_selector=Pin)
  Z6220 = VPROBE(Name=SD_DQ14_G16_U1_rx)
  A6230 = EYEPROBE(source_name=AEYESOURCEEYESRC24 Name=SD_DQ14_G16_U1_rx_eye)
  UU1_SD_DQ11_rx = CCLK_SAPPHIRE_FPGA-new(model=lvc330axxxeaaaaaaain buffer=input polarity=Non-Inverting typ=typ,min,max,fast,slow pkg_selector=Pin)
  Z6300 = VPROBE(Name=SD_DQ11_F15_U1_rx)
  A6310 = EYEPROBE(source_name=AEYESOURCEEYESRC25 Name=SD_DQ11_F15_U1_rx_eye)
  UU1_SD_DQ12_rx = CCLK_SAPPHIRE_FPGA-new(model=lvc330axxxeaaaaaaain buffer=input polarity=Non-Inverting typ=typ,min,max,fast,slow pkg_selector=Pin)
  Z6380 = VPROBE(Name=SD_DQ12_F16_U1_rx)
  A6390 = EYEPROBE(source_name=AEYESOURCEEYESRC26 Name=SD_DQ12_F16_U1_rx_eye)
  UU1_SD_DQ9_rx = CCLK_SAPPHIRE_FPGA-new(model=lvc330axxxeaaaaaaain buffer=input polarity=Non-Inverting typ=typ,min,max,fast,slow pkg_selector=Pin)
  Z6460 = VPROBE(Name=SD_DQ9_E15_U1_rx)
  A6470 = EYEPROBE(source_name=AEYESOURCEEYESRC27 Name=SD_DQ9_E15_U1_rx_eye)
  UU1_SD_DQ10_rx = CCLK_SAPPHIRE_FPGA-new(model=lvc330axxxeaaaaaaain buffer=input polarity=Non-Inverting typ=typ,min,max,fast,slow pkg_selector=Pin)
  Z6540 = VPROBE(Name=SD_DQ10_E16_U1_rx)
  A6550 = EYEPROBE(source_name=AEYESOURCEEYESRC28 Name=SD_DQ10_E16_U1_rx_eye)
nets:
  eyesrc_driver0: AEYESRC0.0
  eyesrc_driver1: AEYESRC1.0
  eyesrc_driver10: AEYESRC10.0
  eyesrc_driver11: AEYESRC11.0
  eyesrc_driver12: AEYESRC12.0
  eyesrc_driver13: AEYESRC13.0
  eyesrc_driver14: AEYESRC14.0
  eyesrc_driver15: AEYESRC15.0
  eyesrc_driver16: AEYESRC16.0
  eyesrc_driver17: AEYESRC17.0
  eyesrc_driver18: AEYESRC18.0
  eyesrc_driver19: AEYESRC19.0
  eyesrc_driver2: AEYESRC2.0
  eyesrc_driver20: AEYESRC20.0
  eyesrc_driver21: AEYESRC21.0
  eyesrc_driver22: AEYESRC22.0
  eyesrc_driver23: AEYESRC23.0
  eyesrc_driver24: AEYESRC24.0
  eyesrc_driver25: AEYESRC25.0
  eyesrc_driver26: AEYESRC26.0
  eyesrc_driver27: AEYESRC27.0
  eyesrc_driver28: AEYESRC28.0
  eyesrc_driver3: AEYESRC3.0
  eyesrc_driver4: AEYESRC4.0
  eyesrc_driver5: AEYESRC5.0
  eyesrc_driver6: AEYESRC6.0
  eyesrc_driver7: AEYESRC7.0
  eyesrc_driver8: AEYESRC8.0
  eyesrc_driver9: AEYESRC9.0
  SD_A0_23_W9825G6KH-6_U5: U100.SD_A0_23_W9825G6KH-6_U5, UU5_SD_A0_rx.0, Z4940.0, A4950.0
  SD_A0_T6_LFE5U-25F-6BG256C_U1: U100.SD_A0_T6_LFE5U-25F-6BG256C_U1, UU1_SD_A0_tx.0, Z2840.0
  SD_A1_24_W9825G6KH-6_U5: U100.SD_A1_24_W9825G6KH-6_U5, Z5100.0, UU5_SD_A1_rx.0, A5110.0
  SD_A1_T4_LFE5U-25F-6BG256C_U1: U100.SD_A1_T4_LFE5U-25F-6BG256C_U1, UU1_SD_A1_tx.0, Z2980.0
  SD_A2_25_W9825G6KH-6_U5: U100.SD_A2_25_W9825G6KH-6_U5, UU5_SD_A2_rx.0, A5030.0, Z5020.0
  SD_A2_T3_LFE5U-25F-6BG256C_U1: U100.SD_A2_T3_LFE5U-25F-6BG256C_U1, UU1_SD_A2_tx.0, Z2910.0
  SD_A3_26_W9825G6KH-6_U5: U100.SD_A3_26_W9825G6KH-6_U5, Z5180.0, UU5_SD_A3_rx.0, A5190.0
  SD_A3_T2_LFE5U-25F-6BG256C_U1: U100.SD_A3_T2_LFE5U-25F-6BG256C_U1, UU1_SD_A3_tx.0, Z3050.0
  SD_A4_29_W9825G6KH-6_U5: U100.SD_A4_29_W9825G6KH-6_U5, UU5_SD_A4_rx.0, Z4700.0, A4710.0
  SD_A4_A2_LFE5U-25F-6BG256C_U1: U100.SD_A4_A2_LFE5U-25F-6BG256C_U1, UU1_SD_A4_tx.0, Z2630.0
  SD_A5_30_W9825G6KH-6_U5: U100.SD_A5_30_W9825G6KH-6_U5, Z4860.0, A4870.0, UU5_SD_A5_rx.0
  SD_A5_A3_LFE5U-25F-6BG256C_U1: U100.SD_A5_A3_LFE5U-25F-6BG256C_U1, UU1_SD_A5_tx.0, Z2770.0
  SD_A6_31_W9825G6KH-6_U5: U100.SD_A6_31_W9825G6KH-6_U5, UU5_SD_A6_rx.0, Z4780.0, A4790.0
  SD_A6_A4_LFE5U-25F-6BG256C_U1: U100.SD_A6_A4_LFE5U-25F-6BG256C_U1, UU1_SD_A6_tx.0, Z2700.0
  SD_BA0_1_0402WGF330JTCE_R54: U100.SD_BA0_1_0402WGF330JTCE_R54, Z4380.0, UR54_SD_BA0_rx.0, A4390.0
  SD_BA0_K12_LFE5U-25F-6BG256C_U1: U100.SD_BA0_K12_LFE5U-25F-6BG256C_U1, UU1_SD_BA0_tx.0, Z2350.0
  SD_BA1_1_0402WGF330JTCE_R53: U100.SD_BA1_1_0402WGF330JTCE_R53, UR53_SD_BA1_rx.0, Z4460.0, A4470.0
  SD_BA1_L12_LFE5U-25F-6BG256C_U1: U100.SD_BA1_L12_LFE5U-25F-6BG256C_U1, UU1_SD_BA1_tx.0, Z2420.0
  SD_CLK_2_0402WGF330JTCE_R2: U100.SD_CLK_2_0402WGF330JTCE_R2, Z4620.0, UR2_SD_CLK_rx.0, A4630.0
  SD_CLK_J15_LFE5U-25F-6BG256C_U1: U100.SD_CLK_J15_LFE5U-25F-6BG256C_U1, UU1_SD_CLK_tx.0, Z2560.0
  SD_CS_N_1_0402WGF330JTCE_R51: U100.SD_CS_N_1_0402WGF330JTCE_R51, Z4300.0, A4310.0, UR51_SD_CS_N_rx.0
  SD_CS_N_R15_LFE5U-25F-6BG256C_U1: U100.SD_CS_N_R15_LFE5U-25F-6BG256C_U1, Z2280.0, UU1_SD_CS_N_tx.0
  SD_DQ0_2_W9825G6KH-6_U5: U100.SD_DQ0_2_W9825G6KH-6_U5, UU5_SD_DQ0_tx.0, Z3260.0
  SD_DQ0_L15_LFE5U-25F-6BG256C_U1: U100.SD_DQ0_L15_LFE5U-25F-6BG256C_U1, UU1_SD_DQ0_rx.0, Z5420.0, A5430.0
  SD_DQ10_45_W9825G6KH-6_U5: U100.SD_DQ10_45_W9825G6KH-6_U5, UU5_SD_DQ10_tx.0, Z4240.0
  SD_DQ10_E16_LFE5U-25F-6BG256C_U1: U100.SD_DQ10_E16_LFE5U-25F-6BG256C_U1, UU1_SD_DQ10_rx.0, Z6540.0, A6550.0
  SD_DQ11_47_W9825G6KH-6_U5: U100.SD_DQ11_47_W9825G6KH-6_U5, UU5_SD_DQ11_tx.0, Z4030.0
  SD_DQ11_F15_LFE5U-25F-6BG256C_U1: U100.SD_DQ11_F15_LFE5U-25F-6BG256C_U1, A6310.0, UU1_SD_DQ11_rx.0, Z6300.0
  SD_DQ12_48_W9825G6KH-6_U5: U100.SD_DQ12_48_W9825G6KH-6_U5, UU5_SD_DQ12_tx.0, Z4100.0
  SD_DQ12_F16_LFE5U-25F-6BG256C_U1: U100.SD_DQ12_F16_LFE5U-25F-6BG256C_U1, A6390.0, Z6380.0, UU1_SD_DQ12_rx.0
  SD_DQ13_50_W9825G6KH-6_U5: U100.SD_DQ13_50_W9825G6KH-6_U5, Z3750.0, UU5_SD_DQ13_tx.0
  SD_DQ13_G15_LFE5U-25F-6BG256C_U1: U100.SD_DQ13_G15_LFE5U-25F-6BG256C_U1, UU1_SD_DQ13_rx.0, A5990.0, Z5980.0
  SD_DQ14_51_W9825G6KH-6_U5: U100.SD_DQ14_51_W9825G6KH-6_U5, Z3960.0, UU5_SD_DQ14_tx.0
  SD_DQ14_G16_LFE5U-25F-6BG256C_U1: U100.SD_DQ14_G16_LFE5U-25F-6BG256C_U1, A6230.0, Z6220.0, UU1_SD_DQ14_rx.0
  SD_DQ15_53_W9825G6KH-6_U5: U100.SD_DQ15_53_W9825G6KH-6_U5, UU5_SD_DQ15_tx.0, Z3890.0
  SD_DQ15_H15_LFE5U-25F-6BG256C_U1: U100.SD_DQ15_H15_LFE5U-25F-6BG256C_U1, UU1_SD_DQ15_rx.0, Z6140.0, A6150.0
  SD_DQ1_4_W9825G6KH-6_U5: U100.SD_DQ1_4_W9825G6KH-6_U5, UU5_SD_DQ1_tx.0, Z3470.0
  SD_DQ1_M16_LFE5U-25F-6BG256C_U1: U100.SD_DQ1_M16_LFE5U-25F-6BG256C_U1, Z5660.0, UU1_SD_DQ1_rx.0, A5670.0
  SD_DQ2_5_W9825G6KH-6_U5: U100.SD_DQ2_5_W9825G6KH-6_U5, UU5_SD_DQ2_tx.0, Z3120.0
  SD_DQ2_K16_LFE5U-25F-6BG256C_U1: U100.SD_DQ2_K16_LFE5U-25F-6BG256C_U1, Z5260.0, A5270.0, UU1_SD_DQ2_rx.0
  SD_DQ3_7_W9825G6KH-6_U5: U100.SD_DQ3_7_W9825G6KH-6_U5, Z3680.0, UU5_SD_DQ3_tx.0
  SD_DQ3_M15_LFE5U-25F-6BG256C_U1: U100.SD_DQ3_M15_LFE5U-25F-6BG256C_U1, UU1_SD_DQ3_rx.0, Z5900.0, A5910.0
  SD_DQ4_8_W9825G6KH-6_U5: U100.SD_DQ4_8_W9825G6KH-6_U5, Z3540.0, UU5_SD_DQ4_tx.0
  SD_DQ4_M14_LFE5U-25F-6BG256C_U1: U100.SD_DQ4_M14_LFE5U-25F-6BG256C_U1, Z5740.0, A5750.0, UU1_SD_DQ4_rx.0
  SD_DQ5_10_W9825G6KH-6_U5: U100.SD_DQ5_10_W9825G6KH-6_U5, UU5_SD_DQ5_tx.0, Z3610.0
  SD_DQ5_P16_LFE5U-25F-6BG256C_U1: U100.SD_DQ5_P16_LFE5U-25F-6BG256C_U1, UU1_SD_DQ5_rx.0, Z5820.0, A5830.0
  SD_DQ6_11_W9825G6KH-6_U5: U100.SD_DQ6_11_W9825G6KH-6_U5, Z3400.0, UU5_SD_DQ6_tx.0
  SD_DQ6_R16_LFE5U-25F-6BG256C_U1: U100.SD_DQ6_R16_LFE5U-25F-6BG256C_U1, A5590.0, UU1_SD_DQ6_rx.0, Z5580.0
  SD_DQ7_13_W9825G6KH-6_U5: U100.SD_DQ7_13_W9825G6KH-6_U5, UU5_SD_DQ7_tx.0, Z3330.0
  SD_DQ7_J16_LFE5U-25F-6BG256C_U1: U100.SD_DQ7_J16_LFE5U-25F-6BG256C_U1, UU1_SD_DQ7_rx.0, Z5500.0, A5510.0
  SD_DQ8_42_W9825G6KH-6_U5: U100.SD_DQ8_42_W9825G6KH-6_U5, UU5_SD_DQ8_tx.0, Z3820.0
  SD_DQ8_D16_LFE5U-25F-6BG256C_U1: U100.SD_DQ8_D16_LFE5U-25F-6BG256C_U1, UU1_SD_DQ8_rx.0, A6070.0, Z6060.0
  SD_DQ9_44_W9825G6KH-6_U5: U100.SD_DQ9_44_W9825G6KH-6_U5, UU5_SD_DQ9_tx.0, Z4170.0
  SD_DQ9_E15_LFE5U-25F-6BG256C_U1: U100.SD_DQ9_E15_LFE5U-25F-6BG256C_U1, UU1_SD_DQ9_rx.0, A6470.0, Z6460.0
  SD_DQM0_15_W9825G6KH-6_U5: U100.SD_DQM0_15_W9825G6KH-6_U5, UU5_SD_DQM0_rx.0, Z5340.0, A5350.0
  SD_DQM0_T15_LFE5U-25F-6BG256C_U1: U100.SD_DQM0_T15_LFE5U-25F-6BG256C_U1, UU1_SD_DQM0_tx.0, Z3190.0
  SD_DQM1_39_W9825G6KH-6_U5: U100.SD_DQM1_39_W9825G6KH-6_U5, A4550.0, UU5_SD_DQM1_rx.0, Z4540.0
  SD_DQM1_D14_LFE5U-25F-6BG256C_U1: U100.SD_DQM1_D14_LFE5U-25F-6BG256C_U1, UU1_SD_DQM1_tx.0, Z2490.0
setups:
  Transient1: TransientData(2E-10, 6.5E-08) TransientNoiseData(false, "", "", 0, 1, 0, false, 1) TransientOtherData(default, false, false)
  QuickEyeAnalysis: QuickEyeAnalysis(false, 0, false, 0, "", true, false, 32)
reports:
  Voltage Waveforms at Drivers: V(SD_CS_N_R15_U1_tx), V(SD_BA0_K12_U1_tx), V(SD_BA1_L12_U1_tx), V(SD_DQM1_D14_U1_tx), V(SD_CLK_J15_U1_tx), V(SD_A4_A2_U1_tx), V(SD_A6_A4_U1_tx), V(SD_A5_A3_U1_tx), V(SD_A0_T6_U1_tx), V(SD_A2_T3_U1_tx), V(SD_A1_T4_U1_tx), V(SD_A3_T2_U1_tx), V(SD_DQ2_5_U5_tx), V(SD_DQM0_T15_U1_tx), V(SD_DQ0_2_U5_tx), V(SD_DQ7_13_U5_tx), V(SD_DQ6_11_U5_tx), V(SD_DQ1_4_U5_tx), V(SD_DQ4_8_U5_tx), V(SD_DQ5_10_U5_tx), V(SD_DQ3_7_U5_tx), V(SD_DQ13_50_U5_tx), V(SD_DQ8_42_U5_tx), V(SD_DQ15_53_U5_tx), V(SD_DQ14_51_U5_tx), V(SD_DQ11_47_U5_tx), V(SD_DQ12_48_U5_tx), V(SD_DQ9_44_U5_tx), V(SD_DQ10_45_U5_tx) vs Time on Transient1 : Transient1
  Voltage Waveforms at Receivers: V(SD_CS_N_1_R51_rx), V(SD_BA0_1_R54_rx), V(SD_BA1_1_R53_rx), V(SD_DQM1_39_U5_rx), V(SD_CLK_2_R2_rx), V(SD_A4_29_U5_rx), V(SD_A6_31_U5_rx), V(SD_A5_30_U5_rx), V(SD_A0_23_U5_rx), V(SD_A2_25_U5_rx), V(SD_A1_24_U5_rx), V(SD_A3_26_U5_rx), V(SD_DQ2_K16_U1_rx), V(SD_DQM0_15_U5_rx), V(SD_DQ0_L15_U1_rx), V(SD_DQ7_J16_U1_rx), V(SD_DQ6_R16_U1_rx), V(SD_DQ1_M16_U1_rx), V(SD_DQ4_M14_U1_rx), V(SD_DQ5_P16_U1_rx), V(SD_DQ3_M15_U1_rx), V(SD_DQ13_G15_U1_rx), V(SD_DQ8_D16_U1_rx), V(SD_DQ15_H15_U1_rx), V(SD_DQ14_G16_U1_rx), V(SD_DQ11_F15_U1_rx), V(SD_DQ12_F16_U1_rx), V(SD_DQ9_E15_U1_rx), V(SD_DQ10_E16_U1_rx) vs Time on Transient1 : Transient1
